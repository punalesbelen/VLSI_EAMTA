** sch_path: /home/eamtastudent/EAMTA2026-VLSI/design/blocks/interruptor/interruptor.sch
**.subckt interruptor N in out P vss vdd
*.iopin N
*.iopin in
*.iopin out
*.iopin vdd
*.iopin vss
*.iopin P
XM1 out P in vdd sg13_lv_pmos w=0.15u l=0.13u ng=1
XM2 out N in vss sg13_lv_nmos w=0.15u l=0.13u ng=1
**.ends
.end
