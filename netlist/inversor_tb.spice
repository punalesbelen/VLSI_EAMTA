** sch_path: /home/eamtastudent/EAMTA2026-VLSI/verification/testbenches/inversor/inversor_tb.sch
**.subckt inversor_tb
C1 net1 avss1p8 1p
V1 avss1p8 GND DC{vss}
V2 avdd1p8 avss1p8 DC{vdd}
V6 vin avss1p8 PULSE({vdd} 0 0.0 1p 1p {Tclk/4} {Tclk/2}) DC 0 AC 0
x1 net2 vout vin avdd1p8 inversor
x2 avss1p8 net1 vout avdd1p8 inversor
**** begin user architecture code

* Circuit Parameters
.param vdd = 1.2
.param vss = 0.0
.param Tclk = 10n
.options TEMP = 27.0
* Include Models - IHP SG13G2
.lib cornerMOSlv.lib mos_tt
* OP Parameters & Singals to save
.save all
*Simulations
.control
tran 0.01u 100n
setplot tran1
plot v(vin) v(vout)+1.2
reset
dc V6 0 1.2 0.01
setplot dc
plot vin vout ylabel vout xlabel vin
set filetype = ascii
write dcsweep.raw
.endc
.end

**** end user architecture code
**.ends

* expanding   symbol:  blocks/inversor/schematic/inversor.sym # of pins=4
** sym_path: /home/eamtastudent/EAMTA2026-VLSI/design/blocks/inversor/schematic/inversor.sym
** sch_path: /home/eamtastudent/EAMTA2026-VLSI/design/blocks/inversor/schematic/inversor.sch
.subckt inversor Vdd out in vss
*.iopin Vdd
*.iopin out
*.iopin vss
*.iopin in
XM1 out in Vdd Vdd sg13_lv_pmos w=0.15u l=0.13u ng=1
XM2 out in vss vss sg13_lv_nmos w=0.15u l=0.13u ng=1
.ends

.GLOBAL GND
.end
