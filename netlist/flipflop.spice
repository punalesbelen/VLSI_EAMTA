** sch_path: /home/eamtastudent/EAMTA2026-VLSI/design/blocks/flipflop/flipflop.sch
**.subckt flipflop D vss clr clk vdd
*.iopin clr
*.iopin vdd
*.iopin vss
*.iopin clk
*.iopin D
x1 clk D net1 nclk vss vdd interruptor
x2 vdd nclk clk vss untitled
x3 nclk net1 net5 clk vss vdd interruptor
x4 vdd net2 net1 vss untitled
x5 nclk net2 net3 clk vss vdd interruptor
x6 vdd net5 net2 clr vss puertanor
x7 clk net3 net4 nclk vss vdd interruptor
x8 vdd net4 net6 vss untitled
x9 vdd net6 net3 clr vss puertanor
**.ends

* expanding   symbol:  blocks/interruptor/interruptor.sym # of pins=6
** sym_path: /home/eamtastudent/EAMTA2026-VLSI/design/blocks/interruptor/interruptor.sym
** sch_path: /home/eamtastudent/EAMTA2026-VLSI/design/blocks/interruptor/interruptor.sch
.subckt interruptor N in out P vss vdd
*.iopin N
*.iopin in
*.iopin out
*.iopin vdd
*.iopin vss
*.iopin P
XM1 out P in vdd sg13_lv_pmos w=0.15u l=0.13u ng=1
XM2 out N in vss sg13_lv_nmos w=0.15u l=0.13u ng=1
.ends

* expanding   symbol:  blocks/inversor/untitled.sym # of pins=4
** sym_path: /home/eamtastudent/EAMTA2026-VLSI/design/blocks/inversor/untitled.sym
** sch_path: /home/eamtastudent/EAMTA2026-VLSI/design/blocks/inversor/untitled.sch
.subckt untitled Vdd Out in Vss
*.iopin Vdd
*.iopin Out
*.iopin Vss
*.iopin in
XM1 Out in Vdd Vdd sg13_lv_pmos w=0.15u l=0.13u ng=1
XM2 Out in Vss Vss sg13_lv_nmos w=0.15u l=0.13u ng=1
.ends

* expanding   symbol:  blocks/puertanor/puertanor.sym # of pins=5
** sym_path: /home/eamtastudent/EAMTA2026-VLSI/design/blocks/puertanor/puertanor.sym
** sch_path: /home/eamtastudent/EAMTA2026-VLSI/design/blocks/puertanor/puertanor.sch
.subckt puertanor vdd vout B A vss
*.iopin vdd
*.iopin vout
*.iopin B
*.iopin vss
*.iopin A
XM1 net1 B vdd vdd sg13_lv_pmos w=0.15u l=0.13u ng=1
XM2 vout A net1 vdd sg13_lv_pmos w=0.15u l=0.13u ng=1
XM3 vout A vss vss sg13_lv_nmos w=0.15u l=0.13u ng=1
XM4 vout B vss vss sg13_lv_nmos w=0.15u l=0.13u ng=1
.ends

.end
