** sch_path: /home/eamtastudent/EAMTA2026-VLSI/verification/testbenches/countador1bit/contador1bit.sch
**.subckt contador1bit
x1 avss out vin avdd avss sout contador1bit
V1 avss 0 DC{vss}
V2 avdd avss DC{vdd}
V6 vin avss PULSE({vdd} 0 0.0 1p 1p {Tclk/4} {Tclk/2}) DC 0 AC 0
**** begin user architecture code

* Circuit Parameters
.param vdd = 1.2
.param vss = 0.0
.param Tclk = 10n
.options TEMP = 27.0
* Include Models - IHP SG13G2
.lib cornerMOSlv.lib mos_tt
* OP Parameters & Singals to save
.save all
*Simulations
.control
tran 0.01u 100n
setplot tran1
plot v(vin) v(vout)
reset
dc V6 0 1.2 0.01
setplot dc
plot vin vout ylabel vout xlabel vin
set filetype = ascii
write dcsweep.raw
.endc
.end

**** end user architecture code
**.ends

* expanding   symbol:  blocks/contador1bit/contador1bit.sym # of pins=6
** sym_path: /home/eamtastudent/EAMTA2026-VLSI/design/blocks/contador1bit/contador1bit.sym
** sch_path: /home/eamtastudent/EAMTA2026-VLSI/design/blocks/contador1bit/contador1bit.sch
.subckt contador1bit clr Dn clk vdd vss sout
*.iopin clr
*.iopin vss
*.iopin vdd
*.iopin sout
*.iopin Dn
*.iopin clk
x1 net2 Dn vss clr clk vdd flipflop
x2 vdd Dn net1 net2 vss puertaxor
x3 vdd sout net1 Dn vss puertaand
.ends

* expanding   symbol:  blocks/flipflop/flipflop.sym # of pins=6
** sym_path: /home/eamtastudent/EAMTA2026-VLSI/design/blocks/flipflop/flipflop.sym
** sch_path: /home/eamtastudent/EAMTA2026-VLSI/design/blocks/flipflop/flipflop.sch
.subckt flipflop D Q vss clr clk vdd
*.iopin clr
*.iopin vdd
*.iopin vss
*.iopin clk
*.iopin D
*.iopin Q
x1 clk D net1 nclk vss vdd interruptor
x2 vdd nclk clk vss untitled
x3 nclk net1 net5 clk vss vdd interruptor
x4 vdd net2 net1 vss untitled
x5 nclk net2 net3 clk vss vdd interruptor
x6 vdd net5 net2 clr vss puertanor
x7 clk net3 net4 nclk vss vdd interruptor
x8 vdd net4 Q vss untitled
x9 vdd Q net3 clr vss puertanor
.ends

* expanding   symbol:  blocks/puertaxor/puertaxor.sym # of pins=5
** sym_path: /home/eamtastudent/EAMTA2026-VLSI/design/blocks/puertaxor/puertaxor.sym
** sch_path: /home/eamtastudent/EAMTA2026-VLSI/design/blocks/puertaxor/puertaxor.sch
.subckt puertaxor Vdd A B Z vss
*.iopin A
*.iopin B
*.iopin vss
*.iopin Z
*.iopin Vdd
XM1 Z A net1 Vdd sg13_lv_pmos w=0.15u l=0.13u ng=1
XM2 net1 bb Vdd Vdd sg13_lv_pmos w=0.15u l=0.13u ng=1
XM3 net1 ab Vdd Vdd sg13_lv_pmos w=0.15u l=0.13u ng=1
XM4 Z B net4 Vdd sg13_lv_pmos w=0.15u l=0.13u ng=1
XM5 Z ab net2 vss sg13_lv_nmos w=0.15u l=0.13u ng=1
XM6 net2 bb vss vss sg13_lv_nmos w=0.15u l=0.13u ng=1
XM7 Z A net3 vss sg13_lv_nmos w=0.15u l=0.13u ng=1
XM8 net3 B vss vss sg13_lv_nmos w=0.15u l=0.13u ng=1
XM9 ab A Vdd Vdd sg13_lv_pmos w=0.15u l=0.13u ng=1
XM10 ab A vss vss sg13_lv_nmos w=0.15u l=0.13u ng=1
XM11 bb B Vdd Vdd sg13_lv_pmos w=0.15u l=0.13u ng=1
XM12 bb B vss vss sg13_lv_nmos w=0.15u l=0.13u ng=1
.ends

* expanding   symbol:  blocks/puertaand/puertaand.sym # of pins=5
** sym_path: /home/eamtastudent/EAMTA2026-VLSI/design/blocks/puertaand/puertaand.sym
** sch_path: /home/eamtastudent/EAMTA2026-VLSI/design/blocks/puertaand/puertaand.sch
.subckt puertaand vdd out A B vss
*.iopin A
*.iopin B
*.iopin vdd
*.iopin vss
*.iopin out
XM1 net2 B vss vss sg13_lv_nmos w=0.15u l=0.13u ng=1
XM2 net1 A net2 vss sg13_lv_nmos w=0.15u l=0.13u ng=1
XM3 net1 A vdd vdd sg13_lv_pmos w=0.15u l=0.13u ng=1
XM4 net1 B vdd vdd sg13_lv_pmos w=0.15u l=0.13u ng=1
XM5 out net1 vdd vdd sg13_lv_pmos w=0.15u l=0.13u ng=1
XM6 out net1 vss vss sg13_lv_nmos w=0.15u l=0.13u ng=1
.ends

* expanding   symbol:  blocks/interruptor/interruptor.sym # of pins=6
** sym_path: /home/eamtastudent/EAMTA2026-VLSI/design/blocks/interruptor/interruptor.sym
** sch_path: /home/eamtastudent/EAMTA2026-VLSI/design/blocks/interruptor/interruptor.sch
.subckt interruptor N in out P vss vdd
*.iopin N
*.iopin in
*.iopin out
*.iopin vdd
*.iopin vss
*.iopin P
XM1 out P in vdd sg13_lv_pmos w=0.15u l=0.13u ng=1
XM2 out N in vss sg13_lv_nmos w=0.15u l=0.13u ng=1
.ends

* expanding   symbol:  blocks/inversor/untitled.sym # of pins=4
** sym_path: /home/eamtastudent/EAMTA2026-VLSI/design/blocks/inversor/untitled.sym
** sch_path: /home/eamtastudent/EAMTA2026-VLSI/design/blocks/inversor/untitled.sch
.subckt untitled Vdd Out in Vss
*.iopin Vdd
*.iopin Out
*.iopin Vss
*.iopin in
XM1 Out in Vdd Vdd sg13_lv_pmos w=0.15u l=0.13u ng=1
XM2 Out in Vss Vss sg13_lv_nmos w=0.15u l=0.13u ng=1
.ends

* expanding   symbol:  blocks/puertanor/puertanor.sym # of pins=5
** sym_path: /home/eamtastudent/EAMTA2026-VLSI/design/blocks/puertanor/puertanor.sym
** sch_path: /home/eamtastudent/EAMTA2026-VLSI/design/blocks/puertanor/puertanor.sch
.subckt puertanor vdd vout B A vss
*.iopin vdd
*.iopin vout
*.iopin B
*.iopin vss
*.iopin A
XM1 net1 B vdd vdd sg13_lv_pmos w=0.15u l=0.13u ng=1
XM2 vout A net1 vdd sg13_lv_pmos w=0.15u l=0.13u ng=1
XM3 vout A vss vss sg13_lv_nmos w=0.15u l=0.13u ng=1
XM4 vout B vss vss sg13_lv_nmos w=0.15u l=0.13u ng=1
.ends

.end
