** sch_path: /home/eamtastudent/VLSI_EAMTA/design/blocks/puertaxor/TOP.sch
.subckt TOP A B vss Z Vdd
*.PININFO A:B B:B vss:B Z:B Vdd:B
M1 Z A net1 Vdd sg13_lv_pmos w=1.5u l=0.15u ng=1
M2 net1 bb Vdd Vdd sg13_lv_pmos w=0.75u l=0.15u ng=1
M3 net1 ab Vdd Vdd sg13_lv_pmos w=1.5u l=0.15u ng=1
M4 Z B net1 Vdd sg13_lv_pmos w=0.75u l=0.15u ng=1
M5 Z ab net2 vss sg13_lv_nmos w=0.75u l=0.15u ng=1
M6 net2 bb vss vss sg13_lv_nmos w=3u l=0.15u ng=1
M7 Z A net3 vss sg13_lv_nmos w=1.5u l=0.15u ng=1
M8 net3 B vss vss sg13_lv_nmos w=3u l=0.15u ng=1
M9 ab A Vdd Vdd sg13_lv_pmos w=0.15u l=0.13u ng=1
M10 ab A vss vss sg13_lv_nmos w=0.15u l=0.13u ng=1
M11 bb B Vdd Vdd sg13_lv_pmos w=0.15u l=0.13u ng=1
M12 bb B vss vss sg13_lv_nmos w=0.15u l=0.13u ng=1
.ends
