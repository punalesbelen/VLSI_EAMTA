* Extracted by KLayout with SG13G2 LVS runset on : 29/04/2026 16:24

.SUBCKT puertaxor
M$1 \$5 \$22 \$7 \$1 sg13_lv_nmos L=0.15u W=0.75u AS=0.255p AD=0.255p PS=2.18u
+ PD=2.18u
M$2 \$6 \$2 \$7 \$1 sg13_lv_nmos L=0.15u W=0.75u AS=0.255p AD=0.255p PS=2.18u
+ PD=2.18u
M$3 \$1 \$22 \$2 \$1 sg13_lv_nmos L=0.15u W=0.75u AS=0.255p AD=0.255p PS=2.18u
+ PD=2.18u
M$4 \$1 \$3 \$4 \$1 sg13_lv_nmos L=0.15u W=0.75u AS=0.255p AD=0.255p PS=2.18u
+ PD=2.18u
M$5 \$1 \$3 \$5 \$1 sg13_lv_nmos L=0.15u W=3u AS=1.02p AD=1.02p PS=6.68u
+ PD=6.68u
M$6 \$1 \$4 \$6 \$1 sg13_lv_nmos L=0.15u W=3u AS=1.02p AD=1.02p PS=6.68u
+ PD=6.68u
M$7 \$12 \$3 \$4 \$12 sg13_lv_pmos L=0.15u W=0.75u AS=0.255p AD=0.255p PS=2.18u
+ PD=2.18u
M$8 \$12 \$22 \$2 \$12 sg13_lv_pmos L=0.15u W=0.75u AS=0.255p AD=0.255p
+ PS=2.18u PD=2.18u
M$9 \$12 \$4 \$15 \$12 sg13_lv_pmos L=0.15u W=0.75u AS=0.255p AD=0.255p
+ PS=2.18u PD=2.18u
M$10 \$15 \$3 \$7 \$12 sg13_lv_pmos L=0.15u W=0.75u AS=0.255p AD=0.255p
+ PS=2.18u PD=2.18u
M$11 \$15 \$22 \$7 \$12 sg13_lv_pmos L=0.15u W=1.5u AS=0.51p AD=0.51p PS=3.68u
+ PD=3.68u
M$12 \$12 \$2 \$15 \$12 sg13_lv_pmos L=0.15u W=1.5u AS=0.51p AD=0.51p PS=3.68u
+ PD=3.68u
.ENDS puertaxor
