* Extracted by KLayout with SG13G2 LVS runset on : 12/04/2026 04:31

.SUBCKT puertaxor
M$1 \$6 \$2 \$5 \$1 sg13_lv_nmos L=0.15u W=0.75u AS=0.525p AD=0.255p PS=3.38u
+ PD=2.18u
M$2 \$1 \$15 \$6 \$1 sg13_lv_nmos L=0.15u W=3u AS=1.02p AD=0.525p PS=6.68u
+ PD=3.38u
M$3 \$4 \$9 \$5 \$1 sg13_lv_nmos L=0.15u W=0.75u AS=0.525p AD=0.255p PS=3.38u
+ PD=2.18u
M$4 \$1 \$3 \$4 \$1 sg13_lv_nmos L=0.15u W=3u AS=1.02p AD=0.525p PS=6.68u
+ PD=3.38u
M$5 \$1 \$15 \$3 \$1 sg13_lv_nmos L=0.15u W=0.75u AS=0.255p AD=0.255p PS=2.18u
+ PD=2.18u
M$6 \$1 \$2 \$9 \$1 sg13_lv_nmos L=0.15u W=0.75u AS=0.255p AD=0.255p PS=2.18u
+ PD=2.18u
M$7 \$14 \$2 \$9 \$14 sg13_lv_pmos L=0.15u W=0.75u AS=0.255p AD=0.255p PS=2.18u
+ PD=2.18u
M$8 \$14 \$15 \$3 \$14 sg13_lv_pmos L=0.15u W=0.75u AS=0.255p AD=0.255p
+ PS=2.18u PD=2.18u
M$9 \$14 \$9 \$18 \$14 sg13_lv_pmos L=0.15u W=0.75u AS=0.255p AD=0.27p PS=2.18u
+ PD=1.88u
M$10 \$18 \$15 \$5 \$14 sg13_lv_pmos L=0.15u W=1.5u AS=0.27p AD=0.51p PS=1.88u
+ PD=3.68u
M$11 \$18 \$2 \$5 \$14 sg13_lv_pmos L=0.15u W=0.75u AS=0.27p AD=0.255p PS=1.88u
+ PD=2.18u
M$12 \$14 \$3 \$18 \$14 sg13_lv_pmos L=0.15u W=1.5u AS=0.51p AD=0.27p PS=3.68u
+ PD=1.88u
.ENDS puertaxor
