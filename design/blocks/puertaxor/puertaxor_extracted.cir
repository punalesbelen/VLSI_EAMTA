* Extracted by KLayout with SG13G2 LVS runset on : 12/04/2026 03:19

.SUBCKT puertaxor
M$1 \$4 \$11 \$1 \$1 sg13_lv_nmos L=0.15u W=0.75u AS=0.255p AD=0.255p PS=2.18u
+ PD=2.18u
M$2 \$5 \$14 \$1 \$1 sg13_lv_nmos L=0.15u W=0.75u AS=0.255p AD=0.255p PS=2.18u
+ PD=2.18u
M$3 \$9 \$17 \$10 \$1 sg13_lv_nmos L=0.15u W=0.75u AS=0.255p AD=0.255p PS=2.18u
+ PD=2.18u
M$4 \$13 \$19 \$13 \$1 sg13_lv_nmos L=0.15u W=1.5u AS=0.51p AD=0.51p PS=3.68u
+ PD=3.68u
M$5 \$8 \$30 \$1 \$1 sg13_lv_nmos L=0.15u W=3u AS=1.02p AD=1.02p PS=6.68u
+ PD=6.68u
M$6 \$12 \$28 \$1 \$1 sg13_lv_nmos L=0.15u W=3u AS=1.02p AD=1.02p PS=6.68u
+ PD=6.68u
M$7 \$22 \$36 \$23 \$57 sg13_lv_pmos L=0.15u W=0.75u AS=0.255p AD=0.255p
+ PS=2.18u PD=2.18u
M$8 \$31 \$35 \$32 \$57 sg13_lv_pmos L=0.15u W=0.75u AS=0.255p AD=0.255p
+ PS=2.18u PD=2.18u
M$9 \$39 \$47 \$40 \$57 sg13_lv_pmos L=0.13u W=0.15u AS=0.1005p AD=0.1005p
+ PS=1.34u PD=1.34u
M$10 \$37 \$50 \$38 \$57 sg13_lv_pmos L=0.15u W=1.5u AS=0.51p AD=0.51p PS=3.68u
+ PD=3.68u
M$11 \$42 \$54 \$43 \$57 sg13_lv_pmos L=0.15u W=0.75u AS=0.255p AD=0.255p
+ PS=2.18u PD=2.18u
M$12 \$44 \$56 \$45 \$57 sg13_lv_pmos L=0.15u W=1.5u AS=0.51p AD=0.51p PS=3.68u
+ PD=3.68u
.ENDS puertaxor
