* NGSPICE netlist for count4bits_2c - IHP SG13G2 PDK
* 4-bit synchronous binary counter (2-complement)
* Generated from count4bits_2c.sch (hierarchical)

* Include lower-level blocks
.include ../count1bit_2c/schematic/count1bit_2c.spice

.subckt count4bits_2c vdd CLK RST vss Q0 Q1 Q2 Q3
* Stage 0 (LSB): EN0 = 1 (always enabled)
Xinv_en0 vdd vss Q0 Q0b inverter
Xcount0 vdd CLK RST vdd vss Q0 CO0 count1bit_2c

* Stage 1: EN1 = CO0
Xcount1 vdd CLK RST CO0 vss Q1 CO1 count1bit_2c

* Stage 2: EN2 = CO1
Xcount2 vdd CLK RST CO1 vss Q2 CO2 count1bit_2c

* Stage 3 (MSB): EN3 = CO2
Xcount3 vdd CLK RST CO2 vss Q3 CO3 count1bit_2c
.ends count4bits_2c
