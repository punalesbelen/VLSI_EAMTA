** sch_path: /home/eamtastudent/VLSI_EAMTA/design/blocks/flipflop/flipflop.sch
.subckt flipflop D Q vss clr clk vdd
*.PININFO clr:B vdd:B vss:B clk:B D:B Q:B
x1 clk D net1 nclk vss vdd interruptor
x2 vdd nclk clk vss untitled
x3 nclk net1 net5 clk vss vdd interruptor
x4 vdd net2 net1 vss untitled
x5 nclk net2 net3 clk vss vdd interruptor
x6 vdd net5 net2 clr vss puertanor
x7 clk net3 net4 nclk vss vdd interruptor
x8 vdd net4 Q vss untitled
x9 vdd Q net3 clr vss puertanor
.ends

* expanding   symbol:  blocks/interruptor/interruptor.sym # of pins=6
** sym_path: /home/eamtastudent/VLSI_EAMTA/design/blocks/interruptor/interruptor.sym
** sch_path: /home/eamtastudent/VLSI_EAMTA/design/blocks/interruptor/interruptor.sch
.subckt interruptor N in out P vss vdd
*.PININFO N:B in:B out:B vdd:B vss:B P:B
M1 out P in vdd sg13_lv_pmos w=1.5u l=0.15u ng=1
M2 out N in vss sg13_lv_nmos w=0.75u l=0.15u ng=1
.ends

* expanding   symbol:  blocks/inversor/untitled.sym # of pins=4
** sym_path: /home/eamtastudent/VLSI_EAMTA/design/blocks/inversor/untitled.sym
** sch_path: /home/eamtastudent/VLSI_EAMTA/design/blocks/inversor/untitled.sch
.subckt untitled Vdd Out in Vss
*.PININFO Vdd:B Out:B Vss:B in:B
M1 Out in Vdd Vdd sg13_lv_pmos w=0.15u l=0.13u ng=1
M2 Out in Vss Vss sg13_lv_nmos w=0.15u l=0.13u ng=1
.ends

* expanding   symbol:  blocks/puertanor/puertanor.sym # of pins=5
** sym_path: /home/eamtastudent/VLSI_EAMTA/design/blocks/puertanor/puertanor.sym
** sch_path: /home/eamtastudent/VLSI_EAMTA/design/blocks/puertanor/puertanor.sch
.subckt puertanor vdd vout B A vss
*.PININFO vdd:B vout:B B:B vss:B A:B
M1 net1 B vdd vdd sg13_lv_pmos w=3u l=0.15u ng=1
M2 vout A net1 vdd sg13_lv_pmos w=3u l=0.15u ng=1
M3 vout A vss vss sg13_lv_nmos w=0.75u l=0.15u ng=1
M4 vout B vss vss sg13_lv_nmos w=0.75u l=0.15u ng=1
.ends
