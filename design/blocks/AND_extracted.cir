* Extracted by KLayout with SG13G2 LVS runset on : 11/03/2026 21:35

.SUBCKT AND
.ENDS AND
