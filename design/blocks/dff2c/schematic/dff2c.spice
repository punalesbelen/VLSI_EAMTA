* NGSPICE netlist for dff2c - IHP SG13G2 PDK
* D Flip-Flop with complementary clocks and clear
* Generated from dff2c.sch (hierarchical)
*
* Uses subcircuits: inverter, norgate, transmissiongate

* Include lower-level blocks
.include ../inverter/schematic/inverter.spice
.include ../norgate/schematic/norgate.spice
.include ../transmissiongate/schematic/transmissiongate.spice

.subckt dff2c vdd D CLK1 CLR vss Q Qb
* Clock buffer
Xinv_clk1 vdd CLK1 vss clk1_neg inverter
* Dual-clock generation
* CLK2 is complementary: CLK2 = NOT(CLK1)
Xinv_clk2 vdd CLK1 vss CLK2 inverter
Xinv_clk2b vdd CLK2 vss clk2_neg inverter

* Master latch (transparent when CLK1=1)
Xtg1 vdd vss D master_in clk1_neg CLK1 transmissiongate
Xnor1 vdd master_in CLR vss master_fb norgate
Xtg2 vdd vss master_fb master_in CLK1 clk1_neg transmissiongate
Xinv_m vdd master_in vss master_out inverter

* Slave latch (transparent when CLK1=0)
Xtg3 vdd vss master_out slave_in CLK1 clk1_neg transmissiongate
Xinv_s1 vdd slave_in vss slave_fb inverter
Xtg4 vdd vss slave_fb slave_in clk1_neg CLK1 transmissiongate
Xinv_q vdd slave_in vss Q inverter
Xinv_qb vdd Q vss Qb inverter
.ends dff2c
