* Extracted by KLayout with SG13G2 LVS runset on : 12/04/2026 05:10

.SUBCKT puertaxor
M$1 \$6 \$19 \$17 \$1 sg13_lv_nmos L=0.15u W=0.75u AS=0.525p AD=0.255p PS=3.38u
+ PD=2.18u
M$2 \$1 \$2 \$6 \$1 sg13_lv_nmos L=0.15u W=3u AS=1.02p AD=0.525p PS=6.68u
+ PD=3.38u
M$3 \$5 \$3 \$17 \$1 sg13_lv_nmos L=0.15u W=0.75u AS=0.525p AD=0.255p PS=3.38u
+ PD=2.18u
M$4 \$1 \$4 \$5 \$1 sg13_lv_nmos L=0.15u W=3u AS=1.02p AD=0.525p PS=6.68u
+ PD=3.38u
M$5 \$1 \$19 \$3 \$1 sg13_lv_nmos L=0.15u W=0.75u AS=0.255p AD=0.255p PS=2.18u
+ PD=2.18u
M$6 \$1 \$2 \$4 \$1 sg13_lv_nmos L=0.15u W=0.75u AS=0.255p AD=0.255p PS=2.18u
+ PD=2.18u
M$7 \$13 \$2 \$4 \$13 sg13_lv_pmos L=0.15u W=0.75u AS=0.255p AD=0.255p PS=2.18u
+ PD=2.18u
M$8 \$13 \$19 \$3 \$13 sg13_lv_pmos L=0.15u W=0.75u AS=0.255p AD=0.255p
+ PS=2.18u PD=2.18u
M$9 \$13 \$4 \$16 \$13 sg13_lv_pmos L=0.15u W=0.75u AS=0.255p AD=0.27p PS=2.18u
+ PD=1.88u
M$10 \$16 \$19 \$17 \$13 sg13_lv_pmos L=0.15u W=1.5u AS=0.27p AD=0.51p PS=1.88u
+ PD=3.68u
M$11 \$16 \$2 \$17 \$13 sg13_lv_pmos L=0.15u W=0.75u AS=0.27p AD=0.255p
+ PS=1.88u PD=2.18u
M$12 \$13 \$3 \$16 \$13 sg13_lv_pmos L=0.15u W=1.5u AS=0.51p AD=0.27p PS=3.68u
+ PD=1.88u
.ENDS puertaxor
