* NGSPICE netlist for count1bit_2c - IHP SG13G2 PDK
* 1-bit counter stage (2-complement implementation)
* Generated from count1bit_2c.sch (hierarchical)
*
* D = Q XOR EN
* CO = Q AND EN

* Include lower-level blocks
.include ../andgate/schematic/andgate.spice
.include ../xorgate/schematic/xorgate.spice
.include ../dff2c/schematic/dff2c.spice
.include ../inverter/schematic/inverter.spice

.subckt count1bit_2c vdd CLK RST EN vss Q CO
* XOR gate: D = Q XOR EN
Xxor1 vdd vss Q EN D xorgate
* D Flip-Flop with clear
Xdff vdd D CLK RST vss Q Qb dff2c
* AND gate for carry out: CO = Q AND EN
Xand1 vdd Q EN vss CO andgate
.ends count1bit_2c
